* TR-808 MID TOM / MID CONGA, main board (service notes p.9, grid H-N 15-27). As the low tom,
* with SW9 also switching C89 across C90 (the bridged-T's input side) in MT.
* Inputs: trig, data (MT instrument data), pn (pink noise). Output: out (IC16a through R239).
* Controls: tuning (VR13 500R B), conga (SW9: 1 = MC), level (VR12 100k A).
.param r242=10k c90=0.027u c92=0.012u c91=0.027u c89=0.0082u r259=820k p13=500
VB5 b5 0 15
VTRIG trig 0 input trig
VDATA data 0 input data
VPN pn 0 input pn
R240 data q53b 22k
R241 q53b 0 10k
Q53 q53c q53b 0 2SC945
R242 q54b q53c {r242}
R243 trig q54b 4.7k
Q54 t q54b trig 2SA733
R251 t 0 4.7k
C86 t a 0.0027u
D58 0 a 1S2473
R255 a b 22k
R254 b 0 6.8k
S9B b r253 conga
R253 r253 0 2.2k
X17A b v o opamp {gbw} 1e5 {opsat} {sr}
S9C v c89 !conga
C89 c89 m {c89}
C90 v m {c90}
C92 m o {c92}
S9A m c91 !conga
C91 c91 o {c91}
R257 v o 820k
R260 m tw 1k
P13 0 tw vr13a {p13} tuning
D82 m vr13a 1S188FM
D83 vr13a m 1S188FM
R258 o n17b 33k
R256 n17b o17b 33k
X17B 0 n17b o17b opamp {gbw} 1e5 {opsat} {sr}
R259 o17b m {r259}
R244 t d57a 4.7k
D57 d57a e 1S2473
C85 e 0 0.033u
R247 e f 2.2meg
C84 f g 0.047u
R245 pn g 15k
R246 g 0 3.3k
R248 f q55b 33k
Q55 q55c q55b 0 2SC945
R252 b5 q55c 4.7k
C87 q55c h 0.033u
R249 h 0 22k
R250 h k 22k
C88 k 0 0.015u
S9D k noise !conga
S9E noise 0 conga
R262 o17b s 100k
R261 noise s 100k
C96 s s16 0.039u
R263 p16 0 47k
X16A p16 s16 o16 opamp {gbw}
R266 s16 o16 470k
C97 s16 o16 0.001u
P12 c95 c95 s16 100k level a0.15
C95 c95 o16 33u
R239 o16 out 1k
* the mix resistor on the jack's normal contact (Jack board B), into IC4a's virtual ground
* with a cable in the jack (plug), the contact opens and the cable's input loads the voice
SMIX out 0 !plug 33k 100k
.control plug 0
.control tuning 0.5
.control conga 0
.control level 0.8
.output out out
* Runtime partitions (docs/model.md, "Partitions"): run in this order; in= nodes come from the others.
.part trig in=f R240 R241 Q53 R242 R243 Q54 R251 C86 D58 R255 R254 S9B R253 R244 D57 C85 R247
.part res in=b X17A S9C C89 C90 C92 S9A C91 R257 R260 P13 D82 D83 R258 R256 X17B R259
.part noise in=e,s sleep R247 C84 R245 R246 R248 Q55 R252 C87 R249 R250 C88 S9D S9E R261
.part out in=o17b,noise R262 R261 C96 R263 X16A R266 C97 P12 C95 R239 SMIX
