* TR-808 voicing board: the common trig narrowed for CB, CY, OH and CH (service notes p.13; p.4:
* "trig variation range is narrowed to 7V-14V by 1/2 IC2 (pins 1-3) on the voicing board to
* increase S/N ratio"). Input: trig (the common trig bus). Output: ntrig (IC2a's output, clipping).
* An accented trig drives IC2a into its output limit, so that limit (ntsat) is the accented level.
* IC2 runs from +B1, +15 V through R165 (100) that also feeds IC5 and IC6 (three uPC4558s, 3 mA
* each typ.): about 14.1 V. The uPC4558 swings 1-2 V under its rail at these loads (+-14 V typ.
* into 10k, +-13 V into 2k; +-12 / +-10 V min.), so a typical part tops out near 12.8 V, not the
* 13.5 V of the other op-amps (opsat). The played unit's is 11.4 V (unitCalibration).
.param ntsat=12.8
VTRIG trig 0 input trig
R19 trig p2 100k
R18 trig d1a 3.3k
D1 d1a 0 1S2473
R20 d1a p2 15k
R21 p2 0 3.3k
R22 n2 0 3.3k
R23 n2 ntrig 100k
X2A p2 n2 ntrig opamp {gbw} 1e5 {ntsat} {sr}
.output ntrig ntrig
