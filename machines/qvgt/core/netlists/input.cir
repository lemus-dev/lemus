* QuadraVerb GT preamp, the input (sheet 1, upper left): LEFT and RIGHT INPUT (J10, J11), U1's
* followers, the INPUT pot (dual 10KB) setting the gain of U2's inverting stages (0 at the left end,
* -10 at the right: 10K against 1K + the pot's track), and U2C's mono sum (R7, R10 470) with a gain
* of 6 (R9 10K / R8 2K). Outputs: p8 (U2 pin 8: the compressor, the gate's detector, the headroom
* LEDs) and the two stages' outputs for the dry path (to U12 on sheet 2).
* The TL084s without their slew limit (13 V/us; audio needs 1.3 at most): with it the solver fails
* where a stage clips, and leaving it out moves a clipping stage's output 80-94 dB under the signal
* against ngspice with it (docs/circuit.md).
.param gbw=3meg gain=2e5 sat=10.5 sr=0
* Each op-amp's input noise as a source in series with its + input (input noise_<part>, 0 V
* unless HISS is on: core/preamp.cpp).
Vinl inl 0 input left
Vinr inr 0 input right
* left: J10 tip, R3 470K to ground, R2 1K into U1D (12 +, 13 -, 14 out) as a follower
R3 inl 0 470k
R2 inl u1dp 1k
X1D nz_1d u1do u1do opamp {gbw} {gain} {sat} {sr}
VNZ_1D nz_1d u1dp input noise_1d
R4 u1do n4 1k
C2 n4 n5 10u
* the INPUT pot's left section: pin 1 (n5) - wiper 5 - pin 3 (U2D's output); clockwise moves the
* wiper to pin 1, the gain's top
P1A n5 w1 u2do 10k input
X2D nz_2d w1 u2do opamp {gbw} {gain} {sat} {sr}
VNZ_2D nz_2d 0 input noise_2d
* right: J11, R1 470K, R5 1K, U1A (3 +, 2 -, 1 out)
R1 inr 0 470k
R5 inr u1ap 1k
X1A nz_1a u1ao u1ao opamp {gbw} {gain} {sat} {sr}
VNZ_1A nz_1a u1ap input noise_1a
R6 u1ao n6 1k
C1 n6 n7 10u
P1B n7 w2 u2ao 10k input
X2A nz_2a w2 u2ao opamp {gbw} {gain} {sat} {sr}
VNZ_2A nz_2a 0 input noise_2a
* the mono sum into U2C (10 +, 9 -, 8 out)
R7 u2do m 470
R10 u2ao m 470
X2C nz_2c n9 p8 opamp {gbw} {gain} {sat} {sr}
VNZ_2C nz_2c m input noise_2c
R8 n9 0 2k
R9 n9 p8 10k
.output p8 p8
.output dryl u2do
.output dryr u2ao
.control input 1
