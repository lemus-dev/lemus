* TB-303 control circuits (docs/circuit.md section 2.4, 4.5, 5, 6.2, 6.4): gate conditioning
* (Q37, Q36, C72), the Q38 one-shot, the MEG (C62, Darlington, Q39, DECAY, diode string), the accent
* switches and ACCENT pot, the accent current into the VCA's I_ABC pin, the accent sweep (D24, R46,
* VR4-B, C13), the cutoff expo converter (Q9, Q10, Q11 with CUT OFF, ENV MOD and TM3) and the VEG
* (Q31, Q32, C42). Included by tools/spice/compare_env.py, which adds the GATE and ACCENT sources
* (nodes ngate, nacc) and sets:
*   tcut, tenv, tdec   the CUT OFF, ENV MOD and DECAY pots' A-taper fractions (0..1)
*   xacc, wres         the ACCENT (B) and RESONANCE (B) rotations
*   tm3                TM3's resistance
* Outputs: v(ngi) GATE_INT, v(nmeg) MEG, i(vabc) the VCA's I_ABC, v(nw4b) the sweep wiper,
* i(vlad) the ladder current.
V12 n12 0 11.85
VREF nref 0 5.333
* --- gate conditioning (2.4)
R146 ngate nb37 22k
R144 nb37 0 10k
Q37 nq37c nb37 0 Q2SC945
R143 nq37c nb36 10k
R142 nb36 n12 10k
C72 nb36 n12 10u
R147 n12 ne36 22
Q36 ngi nb36 ne36 Q2SA733
R145 ngi 0 10k
* --- Q38 one-shot (5.1)
R150 n12 ne38 22
C55 ne38 0 47u
R149 nb38 n12 10k
C54 nq37c nc54 0.047u
R148 nc54 nb38 10k
Q38 nc38 nb38 ne38 Q2SA733
R151 nc38 0 22k
* --- MEG (5.2): attack through D37/R152, Darlington buffer into the Q39 sink, decay into the string
D37 nc38 nd37 D1S
R152 nd37 nc62 100
C62 nc62 0 1u
Q41 n12 nc62 ne41 Q2SC945
Q40 n12 ne41 nmeg Q2SC945
J39 nmeg 0 0 J2SK30Y
R138 nc62 ndec 68k
RVR6 ndec nstr {1e6*tdec+1}
SB ndec nstr nacc 0 SW4066
D28 nstr nd28 D1S
D27 nd28 nd27 D1S
D26 nd27 0 D1S
R117 nref nd27 22k
* --- accent switch A and the ACCENT pot (5.3): VR7 50k B, pin 1 to ground
SA nmeg nvr7 nacc 0 SW4066
RVR7a nvr7 nacw {50k*(1-xacc)+1}
RVR7b nacw 0 {50k*xacc+1}
* --- accent into the VCA's I_ABC pin (6.4)
R119 nacw nc36 47k
C36 nc36 0 0.033u
R120 nc36 nd27a 22k
D27A nd27a npin1 D1S
* --- accent sweep (5.5): D24, R46 into VR4-B pin 1; pin 3 to C13; wiper via R72 to the summing node
D24 nacw nd24 D1S
R46 nd24 nvr4 47k
RVR4ba nvr4 nw4b {50k*wres+1}
RVR4bb nw4b nc13 {50k*(1-wres)+1}
C13 nc13 0 1u
R72 nw4b nsum 100k
* --- cutoff expo converter (4.5)
R65 nref nb9 10k
R64 nb9 0 10k
Q9 0 nb9 nE Q2SA733
RVR3a n12 nw3 {50k*(1-tcut)+1}
RVR3b nw3 n3p1 {50k*tcut+1}
R47 n3p1 nE 10k
R73 nw3 nrt 100k
RTM3 nrt nrefn {tm3}
Q10 nE nsum nrefn Q2SA733
Q11 nq11c nrefn nE Q2SC945
R71 nsum nE 2.2k
RVR5a nmeg nw5 {50k*(1-tenv)+1}
RVR5b nw5 n5p1 {50k*tenv+1}
R61 n5p1 nE 10k
R63 nw5 nsum 220k
* Q11's collector into the ladder: R69 to Q12's emitters (~4.83 V, from the VCF's operating point)
R69 nq11c nlad 2.2k
Vlad n12e nlad 0
Vq12e n12e 0 4.83
* --- VEG (6.2): Q32 discharges C42 on the pulse, R123 recharges it, Q31 sources I_ABC
D36 nc38 nd36 D1S
R134 nd36 nb32 22k
C41 nb32 0 0.1u
Q32 nc32 nb32 ne32 Q2SC945
R130 ne32 0 100
R132 nc32 nN 100
C42 nN 0 1u
R123 n12 nN 1.5Meg
D35 ngi nd35 D1S
R133 nd35 nr131 2.2k
R131 nr131 ne31 220k
Q31 npin1 nN ne31 Q2SA733
* IC15 BA662 (tools/spice/ba662.lib): vabc measures the current into its I_ABC input (pin 1);
* inputs at the bias, output loaded as in the VCA
Vabc npin1 nic1 0
XIC15 nic1 nref nref n12 0 nic6 nic6 nic8 n12 BA662
RIC6 nic6 nref 52.5k
.model SW4066 SW(VT=6 VH=0.5 RON=200 ROFF=1G)
* 2SK30A-Y (Toshiba 2SK30ATM data sheet): IDSS 1.20-3.00 mA for the Y rank; 2 mA with VTO -1.5 V
* (the sheet's VGS(off)-IDSS curve: about -1.5 V at 2 mA).
.model J2SK30Y NJF(VTO=-1.5 BETA=0.89m LAMBDA=0.01 IS=1e-14 CGS=8p CGD=3p)
