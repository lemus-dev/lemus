* SH-101 ENV GEN (docs/circuit-filter.md 5) at transistor level: the gate input (TR29), the
* GATE level for the VCA (TR30, R142, R41, C57), the reset (TR32, TR33, D33), the attack
* (TR34), the end-of-attack comparator IC16a with its latch (D34, R160, R161; R162 placed
* between IC16b's output and IC16a's input, see the text), the decay (TR35 into the SUSTAIN
* follower TR37/TR36), the release (TR31 into R163/C58), C59 and IC16b.
* compare_env.py fills in the pots, the gate and the pin-84 line.
.include models.lib
Vbus bus 0 5.0
* Every rail arrow here is SN p.7's filled one: +14 V, TR3's emitter (14.3 V measured, U-Labor).
* The netlists and the model run at 25 C, the device cards' temperature (models.lib).
.options temp=25
V14 v14 0 14.3

* Gate in (the CPU's GATE, 0/12 V) and S7 deck 2's line into R147.
{GATE}
{PIN84}
R151 gate b29 100k
R150 b29 0 33k
Q29 g b29 0 Q2SC1815
R145 v14 b30 10k
R144 b30 g 100k
Q30 c30 b30 v14 Q2SA1015
R142 c30 n83 12k
R41 n83 bus 33k
C57 n83 0 47n

* Reset: TR32 (from the gate through R149, or pin 84 through R147), TR33, D33.
R149 g b32 220k
R147 pin84 b32 220k
Q32 k b32 0 Q2SC1815
R152 k l 100k
R153 v14 l 10k
Q33 p l v14 Q2SA1015
R146 p bus 100k
D33 m3 k D1S
D32 p q D1S
R157 p b31 47k

* Release: TR31 from the RELEASE pot (R148 220) into R163 47 / C58 10u.
Q31 c31 b31 e31 Q2SC1815
R148 c31 rr 220
RRel rr c59 {RREL}
R163 e31 bus 47
C58 e31 0 10u

* Attack: TR34 from +14 V through R141 270 and the ATTACK pot.
R156 o16a q 47k
R155 q s34 10k
R154 v14 s34 10k
Q34 c34 s34 v14 Q2SA1015
R141 c34 ra 270
RAtt ra c59 {RATT}

* IC16a, the end-of-attack comparator: + from IC16b's output through R162, - the threshold.
R162 env m3 100k
XIC16a m3 th o16a v14 0 IR9022
R161 v14 nn 33k
R160 o16a nn 47k
D34 nn m3 D1S

* Decay: TR35 into the SUSTAIN follower (TR37, TR36).
R159 o16a b35 33k
R165 b35 tt 10k
Q35 c35 b35 tt Q2SC1815
R164 c35 rd 150
RDec rd c59 {RDEC}
Q36 0 u tt Q2SA1015
R166 u 0 33k
Q37 v14 sw u Q2SC1815

* Threshold and SUSTAIN: R158 82k from +14 V, VR24 100k B to the bus (pins 90, 91, 89).
R158 v14 th 82k
RS1 th sw {RSTOP}
RS2 sw bus {RSBOT}

* C59 and IC16b.
C59 c59 0 4.7u
XIC16b c59 env env v14 0 IR9022
* S6's ENV contact, open here: R197 from the ENV line, R196 from +14 V (the board diagram's places).
R197 env s6 3.3k
R196 v14 s6 120k

{VCALOAD}
* the operating point (gate off) starts every run
{ANALYSIS}
.end
