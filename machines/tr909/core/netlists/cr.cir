* TR-909 CRASH, voicing board 73133090, analog half (service notes p.11, grid B-F 11-20, crop
* p11-cy-crash.png; p.5 "DIGITAL VOICE GENERATORS"; docs/circuit/cymbals.md). The clock (IC59b/c,
* VR25 TUNE; C50/R189) is crclk.cir; the logic between it and the D/As (timing flip-flops IC60,
* counters IC61 + IC58a, ROM IC62, latch IC63, NANDs IC59a/d) is core/cymbals.* (Cymbal), which
* gives this netlist the latch's and counter's outputs and IC59d's.
* Inputs: d0..d5, IC63's outputs (4174 on +5 V, 0/5 V, averaged over each step by Cymbal) into RA10's
* 32R .. R, i.e. the ROM byte's bits 2..7 (the public images are in D/A order: bit 7 is the MSB);
* e0..e5, counter bits 9..14 (IC61 Q10-Q12, IC58a Q1-Q3) into RA11's 32R .. R; run, IC59d's output
* (NOT counter bit 15: 5 V while the counter runs); rd.run, the ride's IC57a output (its load on the
* shared accent DAC moves with it); acc, the open-circuit voltage of accent DAC IC9 (RA8, address
* 4008, shared with the ride; 5 V code/63).
* Outputs: out, IC65a at the voicing board's connector W5 (CN-5 pin 41) to the multi-jack board;
* jack, the MULTI OUT jack's contact behind R524/C509 with nothing plugged in (the mix resistors on it).
* Controls: level (VR24 50k B, a rheostat in IC65a's feedback).
* RA10 (RM0621, R = 5k binary weighted) through C127 drives the 22 ohm R431: a current into the VCA
* Q71, a saturated NPN between that node and IC51b's virtual ground whose conductance follows its
* base current. That current is the anti-log pair Q70's: IC52b forces Q70's reference collector to
* the envelope current (5 V - RA11) / R432 (RA11 counts up, so the current falls in 64 steps of 512
* samples to none), and the accent (R426), RUN (R427, the mute when stopped) and R428 set the
* reference base against R429's, so the gain is exponential in the accent. Then two unity-gain
* Sallen-Key low-passes with emitter followers Q75, Q76 (about 4th-order Butterworth at 27 kHz),
* C132 and the LEVEL stage IC65a.
* rlatch: IC63's and the counters' output resistance (HD14174B at 5 V, ~0.9 mA at 0.4 V drop), also
* taken for IC59d and the ride's IC57a (4011UB); rdac: IC9's RM0621 Thevenin resistance (5k || 10k
* || ... || 160k).
.param rlatch=450 rdac=2.54k
VB15 b15 0 15
VNB15 nb15 0 -15
VV5 v5 0 5
VACC acc 0 input acc
VRUN run 0 input run
VRDRUN rdrun 0 input rd.run
VD0 d0 0 input d0
VD1 d1 0 input d1
VD2 d2 0 input d2
VD3 d3 0 input d3
VD4 d4 0 input d4
VD5 d5 0 input d5
VE0 e0 0 input e0
VE1 e1 0 input e1
VE2 e2 0 input e2
VE3 e3 0 input e3
VE4 e4 0 input e4
VE5 e5 0 input e5
* --- the envelope: counter bits 9-14 through RA11 and R432 into IC52b's virtual node at +5 V ------
RLE0 e0 l6 {rlatch}
RLE1 e1 l7 {rlatch}
RLE2 e2 l8 {rlatch}
RLE3 e3 l9 {rlatch}
RLE4 e4 l10 {rlatch}
RLE5 e5 l11 {rlatch}
RA11F l6 ea 160k
RA11E l7 ea 80k
RA11D l8 ea 40k
RA11C l9 ea 20k
RA11B l10 ea 10k
RA11A l11 ea 5k
R432 ea n52b 270k
* the anti-log pair Q70 (2SA798): IC52b holds Q70A's collector at its - input (+5 V), so Q70A carries
* the envelope current; Q70B's collector feeds Q71's base
X52B v5 n52b o52b opamp {gbw}
C126 n52b o52b 1000p
R430 o52b q70e 2.2k
Q70A n52b q70b1 q70e 2SA798
* the reference base: R428 to +5 V, R426 from the accent DAC, R427 from IC59d (RUN)
RRUN run rn {rlatch}
R428 v5 q70b1 220
R426 ac q70b1 4.7k
R427 rn q70b1 2.2k
* accent DAC IC9 (RA8), shared with the ride: its source resistance, and the ride's base network
* on it (R435 to its reference base, R433 to +5 V, R437 to its IC57a); the ride's base current
* (tens of nA through 200 ohms) is left out
RDAC acc ac {rdac}
R435 ac rdb 4.7k
R433 v5 rdb 220
RRD rdrun rdr {rlatch}
R437 rdr rdb 2.2k
* --- the D/A and the VCA ------------------------------------------------------------------------
R429 v5 q70b2 100
Q70B q71b q70b2 q70e 2SA798
* IC63's outputs through RA10 (R = 5k: d5 into R, d0 into 32R) to C127
RL0 d0 l0 {rlatch}
RL1 d1 l1 {rlatch}
RL2 d2 l2 {rlatch}
RL3 d3 l3 {rlatch}
RL4 d4 l4 {rlatch}
RL5 d5 l5 {rlatch}
RA10F l0 da 160k
RA10E l1 da 80k
RA10D l2 da 40k
RA10C l3 da 20k
RA10B l4 da 10k
RA10A l5 da 5k
C127 da vn 10u
R431 vn 0 22
* Q71 (S): collector on the 22 ohm node, emitter at IC51b's virtual ground, R425 the I-V
Q71 vn q71b n51b 2SC2603S
X51B 0 n51b o51b opamp {gbw}
R425 n51b o51b 47k
* --- the filter: two unity-gain Sallen-Key low-passes, emitter followers Q75, Q76 ----------------
R456 o51b s1 5.6k
C136 s1 q75e 1200p
R457 s1 q75b 5.6k
C137 q75b 0 1000p
Q75 b15 q75b q75e 2SC2603
R458 q75e nb15 10k
R459 q75e s2 5.6k
C138 s2 q76e 2700p
R461 s2 q76b 5.6k
C139 q76b 0 390p
Q76 b15 q76b q76e 2SC2603
R460 q76e nb15 10k
* LEVEL: C132, R445 into IC65a with VR24 in its feedback
C132 q76e c132 10u
R445 c132 n65a 22k
X65A 0 n65a out opamp {gbw} 1e5 {opsat}
P24 out out n65a 50k level
* the multi-jack board's load on W5 (JK-1, SN p.12): R524, C509 (from SN 415300) and the mix
* resistors R525 12k, R526 10k into the mix amplifiers' virtual grounds (mix.cir has them)
R524 out jack 1k
C509 jack 0 0.01u
R525 jack 0 12k
R526 jack 0 10k
.control level 0.5
.output out out
.output jack jack
* Runtime partitions (docs/model.md, "Partitions"): run in this order; in= nodes come from the others.
* The envelope and the anti-log pair's reference side (cut at Q70's emitters: IC52b holds them where
* Q70A carries the envelope current, whatever Q70B draws), then the D/A and VCA to IC51b, then the
* filter and LEVEL, which sleep on their own while the VCA is shut.
.part env RLE0 RLE1 RLE2 RLE3 RLE4 RLE5 RA11F RA11E RA11D RA11C RA11B RA11A R432 X52B C126 R430 Q70A
+ RRUN R428 R426 R427 RDAC R435 R433 RRD R437
.part vca in=q70e sleep R429 Q70B RL0 RL1 RL2 RL3 RL4 RL5 RA10F RA10E RA10D RA10C RA10B RA10A C127
+ R431 Q71 X51B R425
.part out in=o51b sleep R456 C136 R457 C137 Q75 R458 R459 C138 R461 C139 Q76 R460 C132 R445 X65A P24
+ R524 C509 R525 R526
